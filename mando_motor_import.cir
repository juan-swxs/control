* Mando bipolar para motor - DAC 3.3 V y push-pull
VDD DAC_3V3 0 DC 3.3
VDAC MANDO_DAC 0 DC 1.65
R101 DAC_3V3 VMITAD 10k
R102 VMITAD 0 10k
C101 VMITAD 0 100n
E101 VREF_BUF 0 VMITAD VREF_BUF 100000
R103 MANDO_DAC ENTRADA_P 10k
R104 ENTRADA_P 0 47k
R105 VREF_BUF ENTRADA_N 10k
R106 MOTOR  ENTRADA_N 47k
E102 OP_IDEAL 0 ENTRADA_P ENTRADA_N 100000
R107 OP_IDEAL BASES 100
VPOTPOS POT_POS 0 DC 12
VPOTNEG POT_NEG 0 DC -12
D101 BASES POT_POS DCLAMP
D102 POT_NEG BASES DCLAMP
Q101 POT_POS BASES BASE_N QNDRV
Q102 POT_POS BASE_N MOTOR QNPWR
Q103 POT_NEG BASES BASE_P QPDRV
Q104 POT_NEG BASE_P MOTOR QPPWR
R108 BASE_N MOTOR 1k
R109 BASE_P MOTOR 1k
D103 MOTOR POT_POS DCLAMP
D104 POT_NEG MOTOR DCLAMP
R110 MOTOR BOBINA 12
L101 BOBINA 0 2m
.model QNDRV NPN(IS=1e-14 BF=100)
.model QPDRV PNP(IS=1e-14 BF=100)
.model QNPWR NPN(IS=1e-12 BF=40)
.model QPPWR PNP(IS=1e-12 BF=40)
.model DCLAMP D(IS=1e-9 RS=0.05)
.END
